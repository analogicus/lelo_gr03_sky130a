*BANDGAP_OTA_PMOS open-loop AC analysis
*This is the OTA actually used in BANDGAP_CIRCUIT — the LVT-PMOS-input
*variant — not the LVT-NMOS-input BANDGAP_OTA cell. Same testbench
*topology as before: DC unity-gain feedback via a huge resistor sets the
*OP, AC stim is applied at IN+, the resistor is effectively open above
*~0.1 Hz so the AC response is the open-loop transfer IN+ -> OUT.
*VCM = 0.7V matches the OTA's input common-mode in BANDGAP_CIRCUIT
*(V_CTAT operating range 0.56-0.81V across PVT, midpoint ~0.7V).

*----------------------------------------------------------------
* Include
*----------------------------------------------------------------
.include ../../../work/xsch/BANDGAP_OTA_PMOS.spice
.include ../../../work/xsch/BIAS_CIRCUIT.spice

*-----------------------------------------------------------------
* OPTIONS
*-----------------------------------------------------------------
.option TNOM=27 GMIN=1e-15 reltol=1e-3

*-----------------------------------------------------------------
* PARAMETERS
*-----------------------------------------------------------------
.param AVDD = {vdda}
.param VCM  = 0.7

*-----------------------------------------------------------------
* FORCE
*-----------------------------------------------------------------
VSS  VSS  0  dc 0
VDD  VDD  VSS  dc {AVDD}
VPWRUP   PWRUP_1V8   VSS  dc {AVDD}
VPWRUP_N PWRUP_N_1V8 VSS  dc 0

* Project bias generator. BANDGAP_OTA_PMOS only takes VB_P as an external
* bias (no V_IB hack needed — the PMOS-input variant exposes only VB_P).
* VB_N is generated by BIAS_CIRCUIT but unused here; left wired so the
* bias generator's mirror branch has a load.
xBIAS VDD PWRUP_1V8 PWRUP_N_1V8 VSS VB_P VB_N BIAS_CIRCUIT

* AC stim on INP via DC source with ac 1.
* INN is wired to the common-mode source via a low-impedance resistor and
* to OUT via huge resistor: the resistor closes unity-gain feedback for DC
* (well-defined OP) but is effectively open at AC.
VCM_SRC VCM_NET VSS dc {VCM}
RFB OUT INN 1G
RIN VCM_NET INN 1
* AC source on INP (regenerated symbol uses INP/INN, not IN+/IN-).
VINP INP VSS dc {VCM} ac 1

* Capacitive output load
CL OUT VSS 1p

*-----------------------------------------------------------------
* DUT
*-----------------------------------------------------------------
.include ../xdut.spi

*----------------------------------------------------------------
* PROBE
*----------------------------------------------------------------
.save all

*----------------------------------------------------------------
* NGSPICE control
*----------------------------------------------------------------
.control
set num_threads=8
set color0=white
set color1=black
unset askquit

* OP via slow VDD ramp (optran) instead of direct `op`. For a self-biased
* PMOS-input OTA the direct OP solver can land in a low-gain zero-current
* equilibrium; ramping VDD from 0 over ~10 us lets the circuit settle at
* the natural operating point. This matches how the existing
* BANDGAP_OTA_LG_TB (Tian-probe loop-gain testbench) drives the OP.
set fend = .raw
foreach vtemp -20 0 25 50 100 125
  option temp=$vtemp
  optran 0 0 0 10n 20u 0
  ac dec 50 1 1G
  write {cicname}_$vtemp$fend
end

quit

.endc

.end
