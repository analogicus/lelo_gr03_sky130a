** sch_path: /home/halst/pro/aicex/ip/lelo_gr03_sky130a/design/LELO_GR03_SKY130A/OSCILLATOR_TB.sch
**.subckt OSCILLATOR_TB
x1 VDD OUT VDD 0 OSCILLATOR
VDD VDD 0 1.8
C1 OUT 0 1f m=1
**** begin user architecture code

.param mc_mm_switch=0
.param mc_pr_switch=0

.lib ../../../tech/ngspice/temperature.spi Tl
.lib ../../../tech/ngspice/corners.spi Kss
.lib ../../../tech/ngspice/supply.spi Vl
.include ../../../../cpdk/ngspice/ideal_circuits.spi
*.option savecurrents
.option gmin=1e-12
*.option SEED=1
.save all
.temp 125
.control

optran 0 0 0 10n 1u 0
*dc VIN 0 1.8 1m
tran 0.1n 2u
*op
*ac dec 20 1 1G

write OSCILLATOR_TB.raw

exit
.endc

**** end user architecture code
**.ends

* expanding   symbol:  LELO_GR03_SKY130A/OSCILLATOR.sym # of pins=4
** sym_path: /home/halst/pro/aicex/ip/lelo_gr03_sky130a/design/LELO_GR03_SKY130A/OSCILLATOR.sym
** sch_path: /home/halst/pro/aicex/ip/lelo_gr03_sky130a/design/LELO_GR03_SKY130A/OSCILLATOR.sch
.subckt OSCILLATOR PWRUP_1V8 F_OUT VDD_1V8 VSS
*.ipin PWRUP_1V8
*.ipin VDD_1V8
*.ipin VSS
*.opin F_OUT
x1 VDD_1V8 VX PWRUP_1V8_BUF V_CTAT VSS PWRUP_N_1V8_BUF BANDGAP_CIRCUIT
x6 PWRUP_1V8 PWRUP_N_1V8_BUF VDD_1V8 VSS JNWTR_IVX1_CV
x2 PWRUP_N_1V8_BUF PWRUP_1V8_BUF VDD_1V8 VSS JNWTR_IVX1_CV
x3<1> VSS VX JNWTR_CAPX4
x3<0> VSS VX JNWTR_CAPX4
x4 VX PWRUP_N_1V8_BUF VSS VSS JNWATR_NCH_4C5F0
x5 VX RST VSS VSS JNWATR_NCH_4C5F0
x8 F_IN net1 VDD_1V8 VSS JNWTR_IVX1_CV
x9 net1 RST VDD_1V8 VSS JNWTR_IVX1_CV
x7 VDD_1V8 VX F_IN V_CTAT VSS PWRUP_N_1V8_BUF PWRUP_1V8_BUF COMPARATOR
x10 net2 F_IN VDD_1V8 F_OUT net2 VDD_1V8 VSS JNWTR_DFRNQNX1_CV
.ends

* expanding   symbol:  LELO_GR03_SKY130A/BANDGAP_CIRCUIT.sym # of pins=6
** sym_path: /home/halst/pro/aicex/ip/lelo_gr03_sky130a/design/LELO_GR03_SKY130A/BANDGAP_CIRCUIT.sym
** sch_path: /home/halst/pro/aicex/ip/lelo_gr03_sky130a/design/LELO_GR03_SKY130A/BANDGAP_CIRCUIT.sch
.subckt BANDGAP_CIRCUIT VDD_1V8 I_PTAT PWRUP_1V8 V_CTAT VSS PWRUP_N_1V8
*.opin I_PTAT
*.opin V_CTAT
*.ipin VDD_1V8
*.ipin VSS
*.ipin PWRUP_1V8
*.ipin PWRUP_N_1V8
x6 VB_P net1 JNWTR_CAPX4
x7 VDD_1V8 DV VB_P V_CTAT VSS PWRUP_N_1V8 PWRUP_1V8 BANDGAP_OTA
XQ1 VSS VSS V_CTAT sky130_fd_pr__pnp_05v5_W3p40L3p40 m=1 mult=1
XQ2<7> VSS VSS VD2 sky130_fd_pr__pnp_05v5_W3p40L3p40 m=1 mult=1
XQ2<6> VSS VSS VD2 sky130_fd_pr__pnp_05v5_W3p40L3p40 m=1 mult=1
XQ2<5> VSS VSS VD2 sky130_fd_pr__pnp_05v5_W3p40L3p40 m=1 mult=1
XQ2<4> VSS VSS VD2 sky130_fd_pr__pnp_05v5_W3p40L3p40 m=1 mult=1
XQ2<3> VSS VSS VD2 sky130_fd_pr__pnp_05v5_W3p40L3p40 m=1 mult=1
XQ2<2> VSS VSS VD2 sky130_fd_pr__pnp_05v5_W3p40L3p40 m=1 mult=1
XQ2<1> VSS VSS VD2 sky130_fd_pr__pnp_05v5_W3p40L3p40 m=1 mult=1
XQ2<0> VSS VSS VD2 sky130_fd_pr__pnp_05v5_W3p40L3p40 m=1 mult=1
x10<3> net1 PWRUP_N_1V8 VDD_1V8 VDD_1V8 JNWATR_PCH_12C1F2
x10<2> net1 PWRUP_N_1V8 VDD_1V8 VDD_1V8 JNWATR_PCH_12C1F2
x10<1> net1 PWRUP_N_1V8 VDD_1V8 VDD_1V8 JNWATR_PCH_12C1F2
x10<0> net1 PWRUP_N_1V8 VDD_1V8 VDD_1V8 JNWATR_PCH_12C1F2
x20 DV VB_P net1 VDD_1V8 JNWATR_PCH_4C5F0
x2 V_CTAT VB_P net1 VDD_1V8 JNWATR_PCH_4C5F0
x3 I_PTAT VB_P net1 VDD_1V8 JNWATR_PCH_4C5F0
x4 VD2 DV VSS JNWTR_RPPO2
.ends

* expanding   symbol:  JNW_TR_SKY130A/JNWTR_IVX1_CV.sym # of pins=4
** sym_path: /home/halst/pro/aicex/ip/lelo_gr03_sky130a/design/JNW_TR_SKY130A/JNWTR_IVX1_CV.sym
** sch_path: /home/halst/pro/aicex/ip/lelo_gr03_sky130a/design/JNW_TR_SKY130A/JNWTR_IVX1_CV.sch
.subckt JNWTR_IVX1_CV A Y AVDD AVSS
*.ipin A
*.opin Y
*.ipin AVDD
*.ipin AVSS
XMN0 Y A AVSS AVSS JNWTR_NCHDL
XMP0 Y A AVDD AVDD JNWTR_PCHDL
.ends

* expanding   symbol:  JNW_TR_SKY130A/JNWTR_CAPX4.sym # of pins=2
** sym_path: /home/halst/pro/aicex/ip/lelo_gr03_sky130a/design/JNW_TR_SKY130A/JNWTR_CAPX4.sym
** sch_path: /home/halst/pro/aicex/ip/lelo_gr03_sky130a/design/JNW_TR_SKY130A/JNWTR_CAPX4.sch
.subckt JNWTR_CAPX4 A B
*.iopin A
*.iopin B
XXA1 A B JNWTR_CAPX1
XXA2 A B JNWTR_CAPX1
XXB1 A B JNWTR_CAPX1
XXB2 A B JNWTR_CAPX1
.ends

* expanding   symbol:  JNW_ATR_SKY130A/JNWATR_NCH_4C5F0.sym # of pins=4
** sym_path: /home/halst/pro/aicex/ip/lelo_gr03_sky130a/design/JNW_ATR_SKY130A/JNWATR_NCH_4C5F0.sym
** sch_path: /home/halst/pro/aicex/ip/lelo_gr03_sky130a/design/JNW_ATR_SKY130A/JNWATR_NCH_4C5F0.sch
.subckt JNWATR_NCH_4C5F0 D G S B
*.iopin D
*.iopin G
*.iopin S
*.iopin B
XM1 D G S B sky130_fd_pr__nfet_01v8 L=0.94 W=3.2 nf=2 ad='int((nf+1)/2) * W/nf * 0.29' as='int((nf+2)/2) * W/nf * 0.29' pd='2*int((nf+1)/2) * (W/nf + 0.29)'
+ ps='2*int((nf+2)/2) * (W/nf + 0.29)' nrd='0.29 / W' nrs='0.29 / W' sa=0 sb=0 sd=0 mult=1 m=1
.ends

* expanding   symbol:  LELO_GR03_SKY130A/COMPARATOR.sym # of pins=7
** sym_path: /home/halst/pro/aicex/ip/lelo_gr03_sky130a/design/LELO_GR03_SKY130A/COMPARATOR.sym
** sch_path: /home/halst/pro/aicex/ip/lelo_gr03_sky130a/design/LELO_GR03_SKY130A/COMPARATOR.sch
.subckt COMPARATOR VDD IN+ OUT IN- VSS PWRUP_N_1V8 PWRUP_1V8
*.ipin IN-
*.opin OUT
*.ipin IN+
*.ipin VSS
*.ipin PWRUP_N_1V8
*.ipin VDD
*.ipin PWRUP_1V8
x18<4> VB_P IN- VTAIL VSS LELOATR_LVT_NCH_4C5F0
x18<3> VB_P IN- VTAIL VSS LELOATR_LVT_NCH_4C5F0
x18<2> VB_P IN- VTAIL VSS LELOATR_LVT_NCH_4C5F0
x18<1> VB_P IN- VTAIL VSS LELOATR_LVT_NCH_4C5F0
x18<0> VB_P IN- VTAIL VSS LELOATR_LVT_NCH_4C5F0
x19<4> V2 IN+ VTAIL VSS LELOATR_LVT_NCH_4C5F0
x19<3> V2 IN+ VTAIL VSS LELOATR_LVT_NCH_4C5F0
x19<2> V2 IN+ VTAIL VSS LELOATR_LVT_NCH_4C5F0
x19<1> V2 IN+ VTAIL VSS LELOATR_LVT_NCH_4C5F0
x19<0> V2 IN+ VTAIL VSS LELOATR_LVT_NCH_4C5F0
x2<2> VTAIL V_IB net1 VSS JNWATR_NCH_4C5F0
x2<1> VTAIL V_IB net1 VSS JNWATR_NCH_4C5F0
x2<0> VTAIL V_IB net1 VSS JNWATR_NCH_4C5F0
x20 V2 VB_P VD VDD JNWATR_PCH_4C5F0
x21 VB_P VB_P VD VDD JNWATR_PCH_4C5F0
x10 OUT V2 VD VDD JNWATR_PCH_4C5F0
x4 V_IB V_IB net1 VSS JNWATR_NCH_4C5F0
x6 OUT V_IB net1 VSS JNWATR_NCH_4C5F0
x1 V_IB VD VSS JNWTR_RPPO16
x9<3> VD PWRUP_N_1V8 VDD VDD JNWATR_PCH_12C1F2
x9<2> VD PWRUP_N_1V8 VDD VDD JNWATR_PCH_12C1F2
x9<1> VD PWRUP_N_1V8 VDD VDD JNWATR_PCH_12C1F2
x9<0> VD PWRUP_N_1V8 VDD VDD JNWATR_PCH_12C1F2
x1<3> net1 PWRUP_1V8 VSS VSS JNWATR_NCH_12C1F2
x1<2> net1 PWRUP_1V8 VSS VSS JNWATR_NCH_12C1F2
x1<1> net1 PWRUP_1V8 VSS VSS JNWATR_NCH_12C1F2
x1<0> net1 PWRUP_1V8 VSS VSS JNWATR_NCH_12C1F2
x9 net2 V2 VSS JNWTR_RPPO2
x11 OUT net2 JNWTR_CAPX4
.ends

* expanding   symbol:  JNW_TR_SKY130A/JNWTR_DFRNQNX1_CV.sym # of pins=7
** sym_path: /home/halst/pro/aicex/ip/lelo_gr03_sky130a/design/JNW_TR_SKY130A/JNWTR_DFRNQNX1_CV.sym
** sch_path: /home/halst/pro/aicex/ip/lelo_gr03_sky130a/design/JNW_TR_SKY130A/JNWTR_DFRNQNX1_CV.sch
.subckt JNWTR_DFRNQNX1_CV D CK RN Q QN AVDD AVSS
*.iopin D
*.iopin CK
*.iopin RN
*.iopin Q
*.iopin QN
*.iopin AVDD
*.iopin AVSS
XXA0 AVDD AVSS JNWTR_TAPCELLB_CV
XXA1 CK RN CKN AVDD AVSS JNWTR_NDX1_CV
XXA2 CKN CKB AVDD AVSS JNWTR_IVX1_CV
XXA3 D CKN CKB A0 AVDD AVSS JNWTR_IVTRIX1_CV
XXA4 A1 CKB CKN A0 AVDD AVSS JNWTR_IVTRIX1_CV
XXA5 A0 A1 AVDD AVSS JNWTR_IVX1_CV
XXA6 A1 CKB CKN QN AVDD AVSS JNWTR_IVTRIX1_CV
XXA7 Q CKN CKB RN QN AVDD AVSS JNWTR_NDTRIX1_CV
XXA8 QN Q AVDD AVSS JNWTR_IVX1_CV
.ends

* expanding   symbol:  LELO_GR03_SKY130A/BANDGAP_OTA.sym # of pins=7
** sym_path: /home/halst/pro/aicex/ip/lelo_gr03_sky130a/design/LELO_GR03_SKY130A/BANDGAP_OTA.sym
** sch_path: /home/halst/pro/aicex/ip/lelo_gr03_sky130a/design/LELO_GR03_SKY130A/BANDGAP_OTA.sch
.subckt BANDGAP_OTA VDD IN+ OUT IN- VSS PWRUP_N_1V8 PWRUP_1V8
*.ipin IN-
*.opin OUT
*.ipin IN+
*.ipin VSS
*.ipin PWRUP_N_1V8
*.ipin VDD
*.ipin PWRUP_1V8
x18<4> VB_P IN- VTAIL VSS LELOATR_LVT_NCH_4C5F0
x18<3> VB_P IN- VTAIL VSS LELOATR_LVT_NCH_4C5F0
x18<2> VB_P IN- VTAIL VSS LELOATR_LVT_NCH_4C5F0
x18<1> VB_P IN- VTAIL VSS LELOATR_LVT_NCH_4C5F0
x18<0> VB_P IN- VTAIL VSS LELOATR_LVT_NCH_4C5F0
x19<4> V2 IN+ VTAIL VSS LELOATR_LVT_NCH_4C5F0
x19<3> V2 IN+ VTAIL VSS LELOATR_LVT_NCH_4C5F0
x19<2> V2 IN+ VTAIL VSS LELOATR_LVT_NCH_4C5F0
x19<1> V2 IN+ VTAIL VSS LELOATR_LVT_NCH_4C5F0
x19<0> V2 IN+ VTAIL VSS LELOATR_LVT_NCH_4C5F0
x2<2> VTAIL V_IB net1 VSS JNWATR_NCH_4C5F0
x2<1> VTAIL V_IB net1 VSS JNWATR_NCH_4C5F0
x2<0> VTAIL V_IB net1 VSS JNWATR_NCH_4C5F0
x20 V2 VB_P VD VDD JNWATR_PCH_4C5F0
x21 VB_P VB_P VD VDD JNWATR_PCH_4C5F0
x10 OUT V2 VD VDD JNWATR_PCH_4C5F0
x4 V_IB V_IB net1 VSS JNWATR_NCH_4C5F0
x6 OUT V_IB net1 VSS JNWATR_NCH_4C5F0
x1 V_IB VD VSS JNWTR_RPPO16
x9<3> VD PWRUP_N_1V8 VDD VDD JNWATR_PCH_12C1F2
x9<2> VD PWRUP_N_1V8 VDD VDD JNWATR_PCH_12C1F2
x9<1> VD PWRUP_N_1V8 VDD VDD JNWATR_PCH_12C1F2
x9<0> VD PWRUP_N_1V8 VDD VDD JNWATR_PCH_12C1F2
x1<3> net1 PWRUP_1V8 VSS VSS JNWATR_NCH_12C1F2
x1<2> net1 PWRUP_1V8 VSS VSS JNWATR_NCH_12C1F2
x1<1> net1 PWRUP_1V8 VSS VSS JNWATR_NCH_12C1F2
x1<0> net1 PWRUP_1V8 VSS VSS JNWATR_NCH_12C1F2
x9 net2 V2 VSS JNWTR_RPPO2
x11 OUT net2 JNWTR_CAPX4
x2 net4 OUT net3 VSS JNWATR_NCH_4C5F0
x3 net3 net3 VSS VSS JNWATR_NCH_4C5F0
x5 net4 net4 VD VDD JNWATR_PCH_4C5F0
x7 OUT net4 VD VDD JNWATR_PCH_4C5F0
x8 OUT OUT VSS VSS JNWATR_NCH_4C5F0
.ends

* expanding   symbol:  JNW_ATR_SKY130A/JNWATR_PCH_12C1F2.sym # of pins=4
** sym_path: /home/halst/pro/aicex/ip/lelo_gr03_sky130a/design/JNW_ATR_SKY130A/JNWATR_PCH_12C1F2.sym
** sch_path: /home/halst/pro/aicex/ip/lelo_gr03_sky130a/design/JNW_ATR_SKY130A/JNWATR_PCH_12C1F2.sch
.subckt JNWATR_PCH_12C1F2 D G S B
*.iopin D
*.iopin G
*.iopin S
*.iopin B
XM1 D G S B sky130_fd_pr__pfet_01v8 L=0.22 W=8.32 nf=2 ad='int((nf+1)/2) * W/nf * 0.29' as='int((nf+2)/2) * W/nf * 0.29' pd='2*int((nf+1)/2) * (W/nf + 0.29)'
+ ps='2*int((nf+2)/2) * (W/nf + 0.29)' nrd='0.29 / W' nrs='0.29 / W' sa=0 sb=0 sd=0 mult=1 m=1
.ends

* expanding   symbol:  JNW_ATR_SKY130A/JNWATR_PCH_4C5F0.sym # of pins=4
** sym_path: /home/halst/pro/aicex/ip/lelo_gr03_sky130a/design/JNW_ATR_SKY130A/JNWATR_PCH_4C5F0.sym
** sch_path: /home/halst/pro/aicex/ip/lelo_gr03_sky130a/design/JNW_ATR_SKY130A/JNWATR_PCH_4C5F0.sch
.subckt JNWATR_PCH_4C5F0 D G S B
*.iopin D
*.iopin G
*.iopin S
*.iopin B
XM1 D G S B sky130_fd_pr__pfet_01v8 L=0.94 W=3.2 nf=2 ad='int((nf+1)/2) * W/nf * 0.29' as='int((nf+2)/2) * W/nf * 0.29' pd='2*int((nf+1)/2) * (W/nf + 0.29)'
+ ps='2*int((nf+2)/2) * (W/nf + 0.29)' nrd='0.29 / W' nrs='0.29 / W' sa=0 sb=0 sd=0 mult=1 m=1
.ends

* expanding   symbol:  JNW_TR_SKY130A/JNWTR_RPPO2.sym # of pins=3
** sym_path: /home/halst/pro/aicex/ip/lelo_gr03_sky130a/design/JNW_TR_SKY130A/JNWTR_RPPO2.sym
** sch_path: /home/halst/pro/aicex/ip/lelo_gr03_sky130a/design/JNW_TR_SKY130A/JNWTR_RPPO2.sch
.subckt JNWTR_RPPO2 N P B
*.iopin P
*.iopin N
*.iopin B
XXA1 N P B JNWTR_RES2
.ends

* expanding   symbol:  JNW_TR_SKY130A/JNWTR_NCHDL.sym # of pins=4
** sym_path: /home/halst/pro/aicex/ip/lelo_gr03_sky130a/design/JNW_TR_SKY130A/JNWTR_NCHDL.sym
** sch_path: /home/halst/pro/aicex/ip/lelo_gr03_sky130a/design/JNW_TR_SKY130A/JNWTR_NCHDL.sch
.subckt JNWTR_NCHDL D G S B
*.iopin D
*.iopin G
*.iopin S
*.iopin B
XM1 D G S B sky130_fd_pr__nfet_01v8 L=0.16 W=0.9 nf=1 ad='int((nf+1)/2) * W/nf * 0.29' as='int((nf+2)/2) * W/nf * 0.29' pd='2*int((nf+1)/2) * (W/nf + 0.29)'
+ ps='2*int((nf+2)/2) * (W/nf + 0.29)' nrd='0.29 / W' nrs='0.29 / W' sa=0 sb=0 sd=0 mult=1 m=1
.ends

* expanding   symbol:  JNW_TR_SKY130A/JNWTR_PCHDL.sym # of pins=4
** sym_path: /home/halst/pro/aicex/ip/lelo_gr03_sky130a/design/JNW_TR_SKY130A/JNWTR_PCHDL.sym
** sch_path: /home/halst/pro/aicex/ip/lelo_gr03_sky130a/design/JNW_TR_SKY130A/JNWTR_PCHDL.sch
.subckt JNWTR_PCHDL D G S B
*.iopin D
*.iopin G
*.iopin S
*.iopin B
XM1 D G S B sky130_fd_pr__pfet_01v8 L=0.16 W=0.9 nf=1 ad='int((nf+1)/2) * W/nf * 0.29' as='int((nf+2)/2) * W/nf * 0.29' pd='2*int((nf+1)/2) * (W/nf + 0.29)'
+ ps='2*int((nf+2)/2) * (W/nf + 0.29)' nrd='0.29 / W' nrs='0.29 / W' sa=0 sb=0 sd=0 mult=1 m=1
.ends

* expanding   symbol:  JNW_TR_SKY130A/JNWTR_CAPX1.sym # of pins=2
** sym_path: /home/halst/pro/aicex/ip/lelo_gr03_sky130a/design/JNW_TR_SKY130A/JNWTR_CAPX1.sym
** sch_path: /home/halst/pro/aicex/ip/lelo_gr03_sky130a/design/JNW_TR_SKY130A/JNWTR_CAPX1.sch
.subckt JNWTR_CAPX1 A B
*.iopin A
*.iopin B
XC1 B A sky130_fd_pr__cap_mim_m3_1 W=5 L=5 MF=1 m=1
.ends

* expanding   symbol:  LELO_ATR_SKY130Aa/LELOATR_LVT_NCH_4C5F0.sym # of pins=4
** sym_path: /home/halst/pro/aicex/ip/lelo_gr03_sky130a/design/LELO_ATR_SKY130Aa/LELOATR_LVT_NCH_4C5F0.sym
** sch_path: /home/halst/pro/aicex/ip/lelo_gr03_sky130a/design/LELO_ATR_SKY130Aa/LELOATR_LVT_NCH_4C5F0.sch
.subckt LELOATR_LVT_NCH_4C5F0 D G S B
*.iopin D
*.iopin G
*.iopin S
*.iopin B
XM1 D G S B sky130_fd_pr__nfet_01v8_lvt L=0.94 W=3.2 nf=2 ad='int((nf+1)/2) * W/nf * 0.29' as='int((nf+2)/2) * W/nf * 0.29' pd='2*int((nf+1)/2) * (W/nf + 0.29)'
+ ps='2*int((nf+2)/2) * (W/nf + 0.29)' nrd='0.29 / W' nrs='0.29 / W' sa=0 sb=0 sd=0 mult=1 m=1
.ends

* expanding   symbol:  JNW_TR_SKY130A/JNWTR_RPPO16.sym # of pins=3
** sym_path: /home/halst/pro/aicex/ip/lelo_gr03_sky130a/design/JNW_TR_SKY130A/JNWTR_RPPO16.sym
** sch_path: /home/halst/pro/aicex/ip/lelo_gr03_sky130a/design/JNW_TR_SKY130A/JNWTR_RPPO16.sch
.subckt JNWTR_RPPO16 N P B
*.iopin P
*.iopin N
*.iopin B
XXA1 N P B JNWTR_RES16
.ends

* expanding   symbol:  JNW_ATR_SKY130A/JNWATR_NCH_12C1F2.sym # of pins=4
** sym_path: /home/halst/pro/aicex/ip/lelo_gr03_sky130a/design/JNW_ATR_SKY130A/JNWATR_NCH_12C1F2.sym
** sch_path: /home/halst/pro/aicex/ip/lelo_gr03_sky130a/design/JNW_ATR_SKY130A/JNWATR_NCH_12C1F2.sch
.subckt JNWATR_NCH_12C1F2 D G S B
*.iopin D
*.iopin G
*.iopin S
*.iopin B
XM1 D G S B sky130_fd_pr__nfet_01v8 L=0.22 W=8.32 nf=2 ad='int((nf+1)/2) * W/nf * 0.29' as='int((nf+2)/2) * W/nf * 0.29' pd='2*int((nf+1)/2) * (W/nf + 0.29)'
+ ps='2*int((nf+2)/2) * (W/nf + 0.29)' nrd='0.29 / W' nrs='0.29 / W' sa=0 sb=0 sd=0 mult=1 m=1
.ends

* expanding   symbol:  JNW_TR_SKY130A/JNWTR_TAPCELLB_CV.sym # of pins=2
** sym_path: /home/halst/pro/aicex/ip/lelo_gr03_sky130a/design/JNW_TR_SKY130A/JNWTR_TAPCELLB_CV.sym
** sch_path: /home/halst/pro/aicex/ip/lelo_gr03_sky130a/design/JNW_TR_SKY130A/JNWTR_TAPCELLB_CV.sch
.subckt JNWTR_TAPCELLB_CV AVDD AVSS
*.iopin AVDD
*.iopin AVSS
XMN1 AVSS AVSS AVSS AVSS JNWTR_NCHDL
XMP1 AVDD AVDD AVDD AVDD JNWTR_PCHDL
.ends

* expanding   symbol:  JNW_TR_SKY130A/JNWTR_NDX1_CV.sym # of pins=5
** sym_path: /home/halst/pro/aicex/ip/lelo_gr03_sky130a/design/JNW_TR_SKY130A/JNWTR_NDX1_CV.sym
** sch_path: /home/halst/pro/aicex/ip/lelo_gr03_sky130a/design/JNW_TR_SKY130A/JNWTR_NDX1_CV.sch
.subckt JNWTR_NDX1_CV A B Y AVDD AVSS
*.iopin A
*.iopin B
*.iopin Y
*.iopin AVDD
*.iopin AVSS
XMN0 N1 A AVSS AVSS JNWTR_NCHDL
XMN1 Y B N1 AVSS JNWTR_NCHDL
XMP0 Y A AVDD AVDD JNWTR_PCHDL
XMP1 AVDD B Y AVDD JNWTR_PCHDL
.ends

* expanding   symbol:  JNW_TR_SKY130A/JNWTR_IVTRIX1_CV.sym # of pins=6
** sym_path: /home/halst/pro/aicex/ip/lelo_gr03_sky130a/design/JNW_TR_SKY130A/JNWTR_IVTRIX1_CV.sym
** sch_path: /home/halst/pro/aicex/ip/lelo_gr03_sky130a/design/JNW_TR_SKY130A/JNWTR_IVTRIX1_CV.sch
.subckt JNWTR_IVTRIX1_CV A C CN Y AVDD AVSS
*.iopin A
*.iopin C
*.iopin CN
*.iopin Y
*.iopin AVDD
*.iopin AVSS
XMN0 N1 A AVSS AVSS JNWTR_NCHDL
XMN1 Y C N1 AVSS JNWTR_NCHDL
XMP0 N2 A AVDD AVDD JNWTR_PCHDL
XMP1 Y CN N2 AVDD JNWTR_PCHDL
.ends

* expanding   symbol:  JNW_TR_SKY130A/JNWTR_NDTRIX1_CV.sym # of pins=7
** sym_path: /home/halst/pro/aicex/ip/lelo_gr03_sky130a/design/JNW_TR_SKY130A/JNWTR_NDTRIX1_CV.sym
** sch_path: /home/halst/pro/aicex/ip/lelo_gr03_sky130a/design/JNW_TR_SKY130A/JNWTR_NDTRIX1_CV.sch
.subckt JNWTR_NDTRIX1_CV A C CN RN Y AVDD AVSS
*.iopin A
*.iopin C
*.iopin CN
*.iopin RN
*.iopin Y
*.iopin AVDD
*.iopin AVSS
XMN2 N1 RN AVSS AVSS JNWTR_NCHDL
XMN0 N2 A N1 AVSS JNWTR_NCHDL
XMN1 Y C N2 AVSS JNWTR_NCHDL
XMP2 AVDD RN N2 AVDD JNWTR_PCHDL
XMP0 N2 A AVDD AVDD JNWTR_PCHDL
XMP1 Y CN N2 AVDD JNWTR_PCHDL
.ends

* expanding   symbol:  JNW_TR_SKY130A/JNWTR_RES2.sym # of pins=3
** sym_path: /home/halst/pro/aicex/ip/lelo_gr03_sky130a/design/JNW_TR_SKY130A/JNWTR_RES2.sym
** sch_path: /home/halst/pro/aicex/ip/lelo_gr03_sky130a/design/JNW_TR_SKY130A/JNWTR_RES2.sch
.subckt JNWTR_RES2 N P B
*.iopin N
*.iopin P
*.iopin B
XR1_0 INT_0 N B sky130_fd_pr__res_high_po W=0.36 L=7.36 mult=1 m=1
XR1_1 P INT_0 B sky130_fd_pr__res_high_po W=0.36 L=7.36 mult=1 m=1
.ends

* expanding   symbol:  JNW_TR_SKY130A/JNWTR_RES16.sym # of pins=3
** sym_path: /home/halst/pro/aicex/ip/lelo_gr03_sky130a/design/JNW_TR_SKY130A/JNWTR_RES16.sym
** sch_path: /home/halst/pro/aicex/ip/lelo_gr03_sky130a/design/JNW_TR_SKY130A/JNWTR_RES16.sch
.subckt JNWTR_RES16 N P B
*.iopin N
*.iopin P
*.iopin B
XR1_0 INT_0 N B sky130_fd_pr__res_high_po W=0.36 L=7.36 mult=1 m=1
XR1_1 INT_1 INT_0 B sky130_fd_pr__res_high_po W=0.36 L=7.36 mult=1 m=1
XR1_2 INT_2 INT_1 B sky130_fd_pr__res_high_po W=0.36 L=7.36 mult=1 m=1
XR1_3 INT_3 INT_2 B sky130_fd_pr__res_high_po W=0.36 L=7.36 mult=1 m=1
XR1_4 INT_4 INT_3 B sky130_fd_pr__res_high_po W=0.36 L=7.36 mult=1 m=1
XR1_5 INT_5 INT_4 B sky130_fd_pr__res_high_po W=0.36 L=7.36 mult=1 m=1
XR1_6 INT_6 INT_5 B sky130_fd_pr__res_high_po W=0.36 L=7.36 mult=1 m=1
XR1_7 INT_7 INT_6 B sky130_fd_pr__res_high_po W=0.36 L=7.36 mult=1 m=1
XR1_8 INT_8 INT_7 B sky130_fd_pr__res_high_po W=0.36 L=7.36 mult=1 m=1
XR1_9 INT_9 INT_8 B sky130_fd_pr__res_high_po W=0.36 L=7.36 mult=1 m=1
XR1_10 INT_10 INT_9 B sky130_fd_pr__res_high_po W=0.36 L=7.36 mult=1 m=1
XR1_11 INT_11 INT_10 B sky130_fd_pr__res_high_po W=0.36 L=7.36 mult=1 m=1
XR1_12 INT_12 INT_11 B sky130_fd_pr__res_high_po W=0.36 L=7.36 mult=1 m=1
XR1_13 INT_13 INT_12 B sky130_fd_pr__res_high_po W=0.36 L=7.36 mult=1 m=1
XR1_14 INT_14 INT_13 B sky130_fd_pr__res_high_po W=0.36 L=7.36 mult=1 m=1
XR1_15 P INT_14 B sky130_fd_pr__res_high_po W=0.36 L=7.36 mult=1 m=1
.ends

.end
